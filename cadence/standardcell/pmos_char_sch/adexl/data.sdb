ADE simulation setup
Run mode: Single Run, Sweeps and Corners
Tests:
  standardcell:pmos_char_sch:1: standardcell/pmos_char_sch/schematic, simulator spectre
Global variables:
  Lg = 500n
  Vsd = 0
  Vsg = 0
